* Nodal 0.0.1 export
V1 N1 0 10
R1 N1 N2 4700
R2 N1 N3 4700
Q1 N2 N4 N5 NODAL_NPN
Q2 N3 N6 N5 NODAL_NPN
R3 N5 0 1300
V2 N4 0 2
V3 N6 0 2.01
.model NODAL_NPN NPN(IS=1e-14 BF=100 BR=1 NF=1 NR=1 VAF=0 VAR=0 IKF=0 IKR=0 ISE=0 ISC=0 RB=0 RE=0 RC=0 CJE=0 CJC=0 CJS=0 TF=0 TR=0)
.options TNOM=27
.end
