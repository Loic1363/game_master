* Nodal 0.0.1 export
V1 N1 0 PWL(0 0 0.0002 5 0.0006 5 0.0008 -2 0.0012 0)
R1 N1 N2 1000
C1 N2 0 1E-07
.options TNOM=27
.end
