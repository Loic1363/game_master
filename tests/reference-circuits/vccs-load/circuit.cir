* Nodal 0.0.1 export
V1 N1 0 1
G1 0 N2 N1 0 0.001
R1 N2 0 2000
.options TNOM=27
.end
