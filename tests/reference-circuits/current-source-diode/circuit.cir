* Nodal 0.0.1 export
I1 N1 0 -0.001
D1 N1 0 NODAL_D
.model NODAL_D D(IS=1e-14 N=1)
.options TNOM=27
.end
