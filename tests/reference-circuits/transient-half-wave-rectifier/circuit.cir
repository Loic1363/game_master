* Nodal 0.0.1 export
V1 N1 0 SIN(0 10 50 0 0 0)
D1 N1 N2 NODAL_D
R1 N2 0 1000
C1 N2 0 0.0001
.model NODAL_D D(IS=1e-14 N=1)
.options TNOM=27
.end
