* Nodal 0.0.1 export
I1 N1 0 -0.001
R1 N1 0 1000
.options TNOM=27
.end
