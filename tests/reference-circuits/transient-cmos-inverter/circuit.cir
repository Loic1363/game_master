* Nodal 0.0.1 export
V1 N1 0 5
M1 N2 N3 N1 N1 NODAL_PMOS W=1e-6 L=1e-6
M2 N2 N3 0 0 NODAL_NMOS W=1e-6 L=1e-6
V2 N3 0 PULSE(0 5 1E-07 1E-09 1E-09 4E-07 1E-06)
C1 N2 0 1E-10
.model NODAL_NMOS NMOS(VTO=1 LEVEL=1 KP=1e-3 LAMBDA=0.02 GAMMA=0 PHI=0.6 IS=1e-14 TOX=0 CGSO=0 CGDO=0 CGBO=0 CBD=0 CBS=0 CJ=0 CJSW=0 JS=0 RD=0 RS=0 RSH=0 LD=0)
.model NODAL_PMOS PMOS(VTO=-1 LEVEL=1 KP=1e-3 LAMBDA=0.02 GAMMA=0 PHI=0.6 IS=1e-14 TOX=0 CGSO=0 CGDO=0 CGBO=0 CBD=0 CBS=0 CJ=0 CJSW=0 JS=0 RD=0 RS=0 RSH=0 LD=0)
.options TNOM=27
.end
