* Nodal 0.0.1 export
V1 N1 0 PULSE(0 5 0 1E-09 1E-09 1 2)
L1 N1 N2 0.001
R1 N2 0 100
.model NODAL_D D(IS=1e-14 N=1)
.options TNOM=27
.end
