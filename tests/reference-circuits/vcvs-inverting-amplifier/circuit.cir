* Nodal 0.0.1 export
V1 N1 0 1
R1 N1 N2 1000
E1 N3 0 0 N2 100000
R2 N2 N3 10000
.options TNOM=27
.end
