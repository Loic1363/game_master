* Nodal 0.0.1 export
V2 N1 0 PULSE(0 5 0 1E-06 1E-06 0.001 0.002)
S1 N2 N3 N1 0 NODAL_SW_S1
V1 N2 0 5
R1 N3 N4 1000
C1 N4 0 1E-06
.model NODAL_SW_S1 SW(VT=2.5 VH=0 RON=1 ROFF=1000000000)
.options TNOM=27
.end
