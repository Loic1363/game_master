* Nodal 0.0.1 export
V1 N1 V1_int 10
RV1 V1_int 0 100
R1 N1 0 220
.model NODAL_D D(IS=1e-14 N=1)
.options TNOM=27
.end
