* Nodal 0.0.1 export
V1 N1 0 1
R1 N1 N2 1000
H1 N3 0 VH1_sense 2000
VH1_sense N2 0 0
R2 N3 0 1000
.options TNOM=27
.end
