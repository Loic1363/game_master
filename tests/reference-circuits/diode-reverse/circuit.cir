* Nodal 0.0.1 export
V1 N1 0 5
R1 N1 N2 1000
D1 0 N2 NODAL_D
.model NODAL_D D(IS=1e-14 N=1)
.options TNOM=27
.end
