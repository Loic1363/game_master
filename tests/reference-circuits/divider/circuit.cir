* Nodal 0.0.1 export
V1 N1 0 10
R1 N1 N2 1000
R2 N2 0 2200
.options TNOM=27
.end
