* Nodal 0.0.1 export
V1 N1 0 1
R1 N1 N2 10
L1 N2 N3 0.001
C1 N3 0 1E-06
.model NODAL_D D(IS=1e-14 N=1)
.options TNOM=27
.end
