* Nodal 0.0.1 export
V1 N1 0 PULSE(0 5 0 1E-09 1E-09 1 2)
R1 N1 N2 1
C1 N2 C1_int1 1E-07
RC1_esr C1_int1 C1_int2 2
LC1_esl C1_int2 0 1E-06
.options TNOM=27
.end
