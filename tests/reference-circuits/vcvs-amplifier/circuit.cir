* Nodal 0.0.1 export
V1 N1 0 0.5
E1 N2 0 N1 0 10
R1 N2 0 1000
.options TNOM=27
.end
