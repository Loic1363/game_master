* Nodal 0.0.1 export
V1 N1 V1_int 12
RV1 V1_int 0 10
R1 N1 0 1000
C1 N1 C1_int1 1E-07
RC1_esr C1_int1 C1_int2 0.05
LC1_esl C1_int2 0 1E-09
RC1 N1 0 1000000
C1_par N1 0 1E-12
L1 N1 L1_int 0.001
RL1 L1_int 0 2
CL1_par N1 0 2E-12
D1 N1 0 NODAL_D
I1 N1 0 -0.002
RI1 N1 0 2200
M1 N1 N1 0 0 NODAL_NMOS W=1e-6 L=1e-6
M2 0 N1 N1 N1 NODAL_PMOS W=1e-6 L=1e-6
Q1 N1 N1 0 NODAL_NPN
Q2 0 N1 N1 NODAL_PNP
E1 N1 0 N1 0 2
G1 0 N1 N1 0 0.005
F1 0 N1 VF1_sense 3
VF1_sense N1 0 0
H1 N1 0 VH1_sense 2000
VH1_sense N1 0 0
S1 N1 0 N1 0 NODAL_SW_S1
SW1 N1 0 SW1_ctrl 0 NODAL_SW_SW1
VSW1_ctrl SW1_ctrl 0 PWL(0 0 0.0009999995 0 0.0010000005 1 0.0029999995 1 0.0030000005000000002 0)
.model NODAL_D D(IS=1e-14 N=1)
.model NODAL_NMOS NMOS(VTO=1 LEVEL=1 KP=1e-3 LAMBDA=0.02 GAMMA=0 PHI=0.6 IS=1e-14 TOX=0 CGSO=0 CGDO=0 CGBO=0 CBD=0 CBS=0 CJ=0 CJSW=0 JS=0 RD=0 RS=0 RSH=0 LD=0)
.model NODAL_PMOS PMOS(VTO=-1 LEVEL=1 KP=1e-3 LAMBDA=0.02 GAMMA=0 PHI=0.6 IS=1e-14 TOX=0 CGSO=0 CGDO=0 CGBO=0 CBD=0 CBS=0 CJ=0 CJSW=0 JS=0 RD=0 RS=0 RSH=0 LD=0)
.model NODAL_NPN NPN(IS=1e-14 BF=100 BR=1 NF=1 NR=1 VAF=0 VAR=0 IKF=0 IKR=0 ISE=0 ISC=0 RB=0 RE=0 RC=0 CJE=0 CJC=0 CJS=0 TF=0 TR=0)
.model NODAL_PNP PNP(IS=1e-14 BF=100 BR=1 NF=1 NR=1 VAF=0 VAR=0 IKF=0 IKR=0 ISE=0 ISC=0 RB=0 RE=0 RC=0 CJE=0 CJC=0 CJS=0 TF=0 TR=0)
.model NODAL_SW_S1 SW(VT=1.5 VH=0.5 RON=2 ROFF=2000000000)
.model NODAL_SW_SW1 SW(VT=0.5 VH=0 RON=0.02 ROFF=1000000000)
.options TNOM=27
.end
