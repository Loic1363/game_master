* Nodal 0.0.1 export
V1 N1 V1_int 12
RV1 V1_int 0 10
R1 N1 0 1000
C1 N1 C1_int1 1E-07
RC1_esr C1_int1 C1_int2 0.05
LC1_esl C1_int2 0 1E-09
RC1 N1 0 1000000
C1_par N1 0 1E-12
L1 N1 L1_int 0.001
RL1 L1_int 0 2
CL1_par N1 0 2E-12
D1 N1 0 NODAL_D
I1 N1 0 -0.002
RI1 N1 0 2200
.model NODAL_D D(IS=1e-14 N=1)
.options TNOM=27
.end
